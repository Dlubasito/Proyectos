** Profile: "SCHEMATIC1-sss"  [ C:\Users\aleja\Desktop\diseños_orCAD\limitador_corriente-PSpiceFiles\SCHEMATIC1\sss.sim ]

** Creating circuit file "sss.cir"
** WARNING: THIS AUTOMATICALLY GENERATED FILE MAY BE OVERWRITTEN BY SUBSEQUENT SIMULATIONS

*Libraries:
* Profile Libraries :
* Local Libraries :
.LIB "../../../limitador_corriente-pspicefiles/limitador_corriente.lib"
* From [PSPICE NETLIST] section of C:\Users\aleja\AppData\Roaming\SPB_16.6\cdssetup\OrCAD_PSpice/16.6.0/PSpice.ini file:
.lib "nomd.lib"

*Analysis directives:
.TRAN  0 10ms 0 100n
.STEP PARAM PARAM LIST 1000 1
.OPTIONS ADVCONV
.PROBE64 V(alias(*)) I(alias(*)) W(alias(*)) D(alias(*)) NOISE(alias(*))
.INC "..\SCHEMATIC1.net"

.END
